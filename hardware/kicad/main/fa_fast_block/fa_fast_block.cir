.title KiCad schematic
.model __Q24 NMOS (LEVEL=1 VTO=1.0 KP=120e-6 GAMMA=0.4 LAMBDA=0.01)
.model __Q23 PMOS (LEVEL=1 VTO=-1.2 KP=60e-6  GAMMA=0.4 LAMBDA=0.01)
.model __Q25 PMOS (LEVEL=1 VTO=-1.2 KP=60e-6  GAMMA=0.4 LAMBDA=0.01)
.model __Q26 NMOS (LEVEL=1 VTO=1.0 KP=120e-6 GAMMA=0.4 LAMBDA=0.01)
.model __Q28 NMOS (LEVEL=1 VTO=1.0 KP=120e-6 GAMMA=0.4 LAMBDA=0.01)
.model __Q27 PMOS (LEVEL=1 VTO=-1.2 KP=60e-6  GAMMA=0.4 LAMBDA=0.01)
.model __Q21 PMOS (LEVEL=1 VTO=-1.2 KP=60e-6  GAMMA=0.4 LAMBDA=0.01)
.model __Q22 NMOS (LEVEL=1 VTO=1.0 KP=120e-6 GAMMA=0.4 LAMBDA=0.01)
.model __Q324 NMOS (LEVEL=1 VTO=1.0 KP=120e-6 GAMMA=0.4 LAMBDA=0.01)
.model __Q326 NMOS (LEVEL=1 VTO=1.0 KP=120e-6 GAMMA=0.4 LAMBDA=0.01)
.model __Q325 PMOS (LEVEL=1 VTO=-1.2 KP=60e-6  GAMMA=0.4 LAMBDA=0.01)
.model __Q323 NMOS (LEVEL=1 VTO=1.0 KP=120e-6 GAMMA=0.4 LAMBDA=0.01)
.model __Q322 NMOS (LEVEL=1 VTO=1.0 KP=120e-6 GAMMA=0.4 LAMBDA=0.01)
.model __Q321 PMOS (LEVEL=1 VTO=-1.2 KP=60e-6  GAMMA=0.4 LAMBDA=0.01)
.model __Q12 NMOS (LEVEL=1 VTO=1.0 KP=120e-6 GAMMA=0.4 LAMBDA=0.01)
.model __Q10 NMOS (LEVEL=1 VTO=1.0 KP=120e-6 GAMMA=0.4 LAMBDA=0.01)
.model __Q11 PMOS (LEVEL=1 VTO=-1.2 KP=60e-6  GAMMA=0.4 LAMBDA=0.01)
.model __Q9 PMOS (LEVEL=1 VTO=-1.2 KP=60e-6  GAMMA=0.4 LAMBDA=0.01)
.model __Q334 NMOS (LEVEL=1 VTO=1.0 KP=120e-6 GAMMA=0.4 LAMBDA=0.01)
.model __Q333 PMOS (LEVEL=1 VTO=-1.2 KP=60e-6  GAMMA=0.4 LAMBDA=0.01)
.model __Q332 NMOS (LEVEL=1 VTO=1.0 KP=120e-6 GAMMA=0.4 LAMBDA=0.01)
.model __Q331 NMOS (LEVEL=1 VTO=1.0 KP=120e-6 GAMMA=0.4 LAMBDA=0.01)
.model __Q329 PMOS (LEVEL=1 VTO=-1.2 KP=60e-6  GAMMA=0.4 LAMBDA=0.01)
.model __Q330 NMOS (LEVEL=1 VTO=1.0 KP=120e-6 GAMMA=0.4 LAMBDA=0.01)
MQ24 Net-_Q24-D_ /YL GND GND __Q24
MQ23 Net-_Q24-D_ /YL VCC VCC __Q23
MQ25 COUT Net-_Q22-D_ VCC VCC __Q25
MQ26 COUT Net-_Q22-D_ GND GND __Q26
MQ28 SUM Net-_Q24-D_ GND GND __Q28
MQ27 SUM Net-_Q24-D_ VCC VCC __Q27
MQ21 Net-_Q22-D_ /I VCC VCC __Q21
MQ22 Net-_Q22-D_ /I GND GND __Q22
Q320 __Q320
Q319 __Q319
MQ324 NC-Q324-0 NC-Q324-1 NC-Q324-2 GND __Q324
MQ326 NC-Q326-0 NC-Q326-1 NC-Q326-2 GND __Q326
MQ325 /YL Net-_Q323-D_ VCC VCC __Q325
MQ323 NC-Q323-0 NC-Q323-1 NC-Q323-2 GND __Q323
Q310 __Q310
Q307 __Q307
Q311 __Q311
Q306 __Q306
Q309 __Q309
Q312 __Q312
Q304 __Q304
Q305 __Q305
Q308 __Q308
Q303 __Q303
MQ322 NC-Q322-0 NC-Q322-1 NC-Q322-2 GND __Q322
MQ321 Net-_Q322-D_ P VCC VCC __Q321
MQ12 P Net-_Q10-D_ GND GND __Q12
MQ10 Net-_Q10-D_ /Y1 GND GND __Q10
MQ11 P Net-_Q10-D_ VCC VCC __Q11
MQ9 Net-_Q10-D_ /Y1 VCC VCC __Q9
MQ334 NC-Q334-0 NC-Q334-1 NC-Q334-2 GND __Q334
MQ333 /Y1 Net-_Q331-D_ VCC VCC __Q333
MQ332 NC-Q332-0 NC-Q332-1 NC-Q332-2 GND __Q332
MQ331 NC-Q331-0 NC-Q331-1 NC-Q331-2 GND __Q331
Q328 __Q328
Q327 __Q327
MQ329 Net-_Q330-D_ B VCC VCC __Q329
MQ330 NC-Q330-0 NC-Q330-1 NC-Q330-2 GND __Q330
.end
