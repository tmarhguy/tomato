.title KiCad schematic
.model __Q24 NMOS
.model __Q23 PMOS
.model __Q25 PMOS
.model __Q26 NMOS
.model __Q28 NMOS
.model __Q27 PMOS
.model __Q21 PMOS
.model __Q22 NMOS
.model __Q324 NMOS
.model __Q326 NMOS
.model __Q325 PMOS
.model __Q323 NMOS
.model __Q322 NMOS
.model __Q321 PMOS
.model __Q12 NMOS
.model __Q10 NMOS
.model __Q11 PMOS
.model __Q9 PMOS
.model __Q334 NMOS
.model __Q333 PMOS
.model __Q332 NMOS
.model __Q331 NMOS
.model __Q329 PMOS
.model __Q330 NMOS
MQ24 Net-_Q24-D_ /YL GND NC-Q24-0 __Q24
MQ23 Net-_Q24-D_ /YL VCC NC-Q23-0 __Q23
MQ25 COUT Net-_Q22-D_ VCC NC-Q25-0 __Q25
MQ26 COUT Net-_Q22-D_ GND NC-Q26-0 __Q26
MQ28 SUM Net-_Q24-D_ GND NC-Q28-0 __Q28
MQ27 SUM Net-_Q24-D_ VCC NC-Q27-0 __Q27
MQ21 Net-_Q22-D_ /I VCC NC-Q21-0 __Q21
MQ22 Net-_Q22-D_ /I GND NC-Q22-0 __Q22
Q320 __Q320
Q319 __Q319
MQ324 NC-Q324-0 NC-Q324-1 NC-Q324-2 NC-Q324-3 __Q324
MQ326 NC-Q326-0 NC-Q326-1 NC-Q326-2 NC-Q326-3 __Q326
MQ325 /YL Net-_Q323-D_ VCC NC-Q325-0 __Q325
MQ323 NC-Q323-0 NC-Q323-1 NC-Q323-2 NC-Q323-3 __Q323
Q310 __Q310
Q307 __Q307
Q311 __Q311
Q306 __Q306
Q309 __Q309
Q312 __Q312
Q304 __Q304
Q305 __Q305
Q308 __Q308
Q303 __Q303
MQ322 NC-Q322-0 NC-Q322-1 NC-Q322-2 NC-Q322-3 __Q322
MQ321 Net-_Q322-D_ P VCC NC-Q321-0 __Q321
MQ12 P Net-_Q10-D_ GND NC-Q12-0 __Q12
MQ10 Net-_Q10-D_ /Y1 GND NC-Q10-0 __Q10
MQ11 P Net-_Q10-D_ VCC NC-Q11-0 __Q11
MQ9 Net-_Q10-D_ /Y1 VCC NC-Q9-0 __Q9
MQ334 NC-Q334-0 NC-Q334-1 NC-Q334-2 NC-Q334-3 __Q334
MQ333 /Y1 Net-_Q331-D_ VCC NC-Q333-0 __Q333
MQ332 NC-Q332-0 NC-Q332-1 NC-Q332-2 NC-Q332-3 __Q332
MQ331 NC-Q331-0 NC-Q331-1 NC-Q331-2 NC-Q331-3 __Q331
Q328 __Q328
Q327 __Q327
MQ329 Net-_Q330-D_ B VCC NC-Q329-0 __Q329
MQ330 NC-Q330-0 NC-Q330-1 NC-Q330-2 NC-Q330-3 __Q330
.end
